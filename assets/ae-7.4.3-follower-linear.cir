* Authored linear small-signal verification, NOT a vendor nonlinear device model
V16 b16 0 1
Rpi16 b16 in 3000
G16 0 in b16 in 0.06666666666666667
R6 in 0 50k
Rpi17 in e 3000
G17 out e in e 0.06666666666666667
Ro17 out e 1meg
Ro13 out 0 1meg
Ri24 out 0 800k
R7 e 0 50

.control
set noaskquit
op
let ri16=-1/i(V16)
print ri16
quit
.endc
.end
