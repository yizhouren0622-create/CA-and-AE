ae-6.3.5-hybrid; authored hybrid-pi AC model, NOT a manufacturer nonlinear BJT
* Bias parameters computed separately using VT=26mV, VBE=0.7V
Vin in 0 DC 0 AC 1
Rsi in a 5000
Cb1 a ext 1e-06
Rbias ext 0 13200.0
Rbb ext b 50
Rpi b e 9701.999999999996
Re e 0 3900
Ce e 0 5e-05
Rc c 0 4700
Cb2 c out 1e-06
Rl out 0 5100
Gm c e b e 0.01236858379715523
Ro c e 300000
Cpi b e 1.8121732148051136e-12
Cmu b c 1e-12
.control
set wr_singlescale
set wr_vecnames
set numdgt=15
ac dec 300 0.01 10000000000.0
wrdata ae-6.3.5-hybrid.dat v(out) v(ext)
.endc
.end
