* Textbook exercise 3.4.6; authored circuit, ngspice 47.
* Diode parameters: OUP Microelectronic Circuits 8e SPICE guide, PDF p.10.
.include UA741.lib
.model D1N4148 D(Is=2.682n N=1.836 Rs=.5664 Ikf=44.17m Xti=3 Eg=1.11 Cjo=4p
+ M=.3333 Vj=.5 Fc=.5 Isr=1.565n Nr=2 Bv=100 Ibv=100u Tt=11.54n)

VCC vp 0 12
VEE vm 0 -12
VIN in 0 DC 0 SIN(0 1 1k)
RIN in n1 10k
RF1 n1 half 10k
D1 oa n1 D1N4148
D2 half oa D1N4148
XA1 0 n1 vp vm oa UA741
RSUM1 in n2 20k
RSUM2 half n2 10k
RF2 out n2 20k
XA2 0 n2 vp vm out UA741
.control
set noaskquit
set wr_singlescale
set wr_vecnames
set numdgt=15
tran 0.1u 6m
wrdata ae-3.4.6-waveforms.dat v(in) v(half) v(out)
dc VIN -1 1 0.001
wrdata ae-3.4.6-transfer.dat v(in) v(half) v(out)
quit
.endc
.end
