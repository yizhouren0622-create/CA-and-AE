* Authored linear small-signal verification, NOT a vendor nonlinear device model
V17 in 0 1
Rpi17 in e 3000
G17 out e in e 0.06666666666666667
Ro17 out e 1meg
Ro13 out 0 1meg
Ri24 out 0 800k
R7 e 0 50

.control
set noaskquit
op
let av=v(out)
let ri17=-1/i(V17)
print av ri17
quit
.endc
.end
