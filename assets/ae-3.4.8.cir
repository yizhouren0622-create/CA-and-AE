* Textbook exercise 3.4.8; authored circuit, ngspice 47.
* Diode parameters: OUP Microelectronic Circuits 8e SPICE guide, PDF p.10.
.model D1N4148 D(Is=2.682n N=1.836 Rs=.5664 Ikf=44.17m Xti=3 Eg=1.11 Cjo=4p
+ M=.3333 Vj=.5 Fc=.5 Isr=1.565n Nr=2 Bv=100 Ibv=100u Tt=11.54n)

VIN in 0 DC 0 SIN(0 10 1k)
R1 in a 200
D1 a out D1N4148
R2 out ref 200
VREF ref 0 6
.control
set noaskquit
set wr_singlescale
set wr_vecnames
set numdgt=15
tran 0.1u 5m
wrdata ae-3.4.8-waveforms.dat v(in) v(out) v(a)
dc VIN -10 10 0.002
wrdata ae-3.4.8-transfer.dat v(in) v(out)
quit
.endc
.end
